* NMOS Id-Vds sanity test
.lib $PDK_ROOT/sky130A/libs.tech/ngspice/sky130.lib.spice tt

XM1 d g 0 0 sky130_fd_pr__nfet_01v8 W=1 L=0.5
VD d 0 0
VG g 0 0.9

.control
dc VD 0 1.8 0.01 VG 0.6 1.2 0.2
let id = -i(VD)
wrdata results/nmos_iv.csv id
echo "Simulation done"
quit
.endc
.end
